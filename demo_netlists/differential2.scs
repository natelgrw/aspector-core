simulator lang=spectre
global 0 gnd! vdd!
parameters fet_num={{fet_num}} use_tran=0 rfeedback_val=1000 dc_offset=0 gain_n=-0.5 tempc={{tempc}} nA1={{nA1}} nB1={{nB1}} nA2={{nA2}} nB2={{nB2}} nA3={{nA3}} nB3={{nB3}} nA4={{nA4}} nB4={{nB4}} vdd={{vdd}} vcm={{vcm}} vbiasp1={{vbiasp1}} vbiasp2={{vbiasp2}} vbiasn0={{vbiasn0}}

{% if fet_num == 7 %}
include "/homes/natelgrw/Documents/titan_foundation_model/lstp/7nfet.pm"
include "/homes/natelgrw/Documents/titan_foundation_model/lstp/7pfet.pm"
{% elif fet_num == 10 %}
include "/homes/natelgrw/Documents/titan_foundation_model/lstp/10nfet.pm"
include "/homes/natelgrw/Documents/titan_foundation_model/lstp/10pfet.pm"
{% elif fet_num == 14 %}
include "/homes/natelgrw/Documents/titan_foundation_model/lstp/14nfet.pm"
include "/homes/natelgrw/Documents/titan_foundation_model/lstp/14pfet.pm"
{% elif fet_num == 16 %}
include "/homes/natelgrw/Documents/titan_foundation_model/lstp/16nfet.pm"
include "/homes/natelgrw/Documents/titan_foundation_model/lstp/16pfet.pm"
{% elif fet_num == 20 %}
include "/homes/natelgrw/Documents/titan_foundation_model/lstp/20nfet.pm"
include "/homes/natelgrw/Documents/titan_foundation_model/lstp/20pfet.pm"
{% endif %}

*---fully_differential_cascode Vbiasn0 Vbiasp1 Vbiasp2 Vinn Vinp Voutn Voutp---
*.PININFO Vbiasn0:I Vbiasp1:I Vbiasp2:I Vinn:I Vinp:I Voutn:O Voutp:O
MM3 Voutn Vinp net16 gnd! nfet l=nA3 nfin=nB3
MM0 Voutp Vinn net16 gnd! nfet l=nA3 nfin=nB3
MM4 net16 Vbiasn0 gnd! gnd! nfet l=nA4 nfin=nB4
MM6 Voutp Vbiasp2 net22 vdd! pfet l=nA1 nfin=nB1
MM5 Voutn Vbiasp2 net21 vdd! pfet l=nA1 nfin=nB1
MM1 net21 Vbiasp1 vdd! vdd! pfet l=nA2 nfin=nB2
MM2 net22 Vbiasp1 vdd! vdd! pfet l=nA2 nfin=nB2

*---Ground, VDD, VCM Declarations---
VS (gnd! 0) vsource dc=0 type=dc
V0 (vdd! gnd!) vsource dc=vdd type=dc
V1 (cm gnd!) vsource dc=vcm type=dc

*---Voltage Input---
V2 (in gnd!) vsource dc=dc_offset type=dc mag=1
E1 (Vinp_norm cm in gnd!) vcvs gain=0.5
E0 (Vinn_norm cm in gnd!) vcvs gain=gain_n

*---Transient Input---
Vstep (in_tran gnd!) vsource type=pulse val0=(0.1 * vdd) val1=(0.9 * vdd) delay=1n rise=50p fall=50p width=100n period=200n
E3 (Vinp_tran cm in_tran gnd!) vcvs gain=0.5
E2 (Vinn_tran cm in_tran gnd!) vcvs gain=-0.5

*--- Switchable Inputs to Core ---
* These drive the real Vinp/Vinn via large resistors (select input path via param)
Rin1 (Vinp Vinp_norm) resistor r=(1 / (1 - use_tran + 1p))
Rin2 (Vinp Vinp_tran) resistor r=(1 / (use_tran + 1p))

Rin3 (Vinn Vinn_norm) resistor r=(1 / (1 - use_tran + 1p))
Rin4 (Vinn Vinn_tran) resistor r=(1 / (use_tran + 1p))

Rfeedback_p (Vinn Voutp) resistor r=((use_tran * rfeedback_val) + ((1 - use_tran) * 1T))
Rfeedback_n (Vinp Voutn) resistor r=((use_tran * rfeedback_val) + ((1 - use_tran) * 1T))

Ctran_p (Voutp gnd!) capacitor c=(use_tran * 50f)
Ctran_n (Voutn gnd!) capacitor c=(use_tran * 50f)

*---Bias Voltages---
VP1 (Vbiasp1 gnd!) vsource dc=vbiasp1 type=dc
VP2 (Vbiasp2 gnd!) vsource dc=vbiasp2 type=dc
VN (Vbiasn0 gnd!) vsource dc=vbiasn0 type=dc

simulatorOptions options psfversion="1.4.0" reltol=1e-3 vabstol=1e-6 \
    iabstol=1e-12 temp=tempc tnom=27 scalem=1.0 scale=1.0 gmin=1e-12 rforce=1 \
    maxnotes=5 maxwarns=5 digits=5 cols=80 pivrel=1e-3 \
    sensfile="../psf/sens.output" checklimitdest=psf

*---Noise Simulation---
noise (Voutp 0) noise start=1M stop=500M dec=20 iprobe=V2 annotate=status

*---AC Sweep---
acswp sweep param=gain_n start=-0.5 stop=0.5 step=1 {
    ac ac start=1 stop=100G dec=10 annotate=status
}

*---DC Sweep---
dcswp sweep param=dc_offset start=-0.5 stop=0.5 step=0.001 {
    dcOp dc write="spectre.dc" maxiters=150 maxsteps=10000 annotate=status
}

*---Transient Sweep---
transwp sweep param=use_tran values=[1] {
    mytran tran stop=200n step=5p annotate=status
}

dcOpInfo info what=oppoint where=rawfile
modelParameter info what=models where=rawfile
element info what=inst where=rawfile
outputParameter info what=output where=rawfile
designParamVals info what=parameters where=rawfile
primitives info what=primitives where=rawfile
subckts info what=subckts where=rawfile

save V0:p  MM0:gm MM0:vgs MM0:vds MM0:ids MM0:region  MM1:gm MM1:vgs MM1:vds MM1:ids MM1:region  MM2:gm MM2:vgs MM2:vds MM2:ids MM2:region  MM3:gm MM3:vgs MM3:vds MM3:ids MM3:region  MM4:gm MM4:vgs MM4:vds MM4:ids MM4:region  MM5:gm MM5:vgs MM5:vds MM5:ids MM5:region  MM6:gm MM6:vgs MM6:vds MM6:ids MM6:region  MM7:gm MM7:vgs MM7:vds MM7:ids MM7:region  MM8:gm MM8:vgs MM8:vds MM8:ids MM8:region  MM9:gm MM9:vgs MM9:vds MM9:ids MM9:region  MM10:gm MM10:vgs MM10:vds MM10:ids MM10:region  MM11:gm MM11:vgs MM11:vds MM11:ids MM11:region  MM12:gm MM12:vgs MM12:vds MM12:ids MM12:region  MM13:gm MM13:vgs MM13:vds MM13:ids MM13:region  MM14:gm MM14:vgs MM14:vds MM14:ids MM14:region
saveOptions options save=allpub rawfmt=psfbin
