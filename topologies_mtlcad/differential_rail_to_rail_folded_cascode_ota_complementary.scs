simulator lang=spectre
global 0 gnd! vdd!
parameters dc_offset=0 run_gatekeeper={{run_gatekeeper}} run_full_char={{run_full_char}} fet_num={{fet_num}} vdd={{vdd}} vcm={{vcm}} tempc={{tempc}} rfeedback_val={{rfeedback_val}} rsrc_val={{rsrc_val}} cload_val={{cload_val}} vbiasn0={{vbiasn0}} vbiasn1={{vbiasn1}} vbiasn2={{vbiasn2}} vbiasp0={{vbiasp0}} vbiasp1={{vbiasp1}} vbiasp2={{vbiasp2}} nA1={{nA1}} nA2={{nA2}} nA3={{nA3}} nA4={{nA4}} nA5={{nA5}} nA6={{nA6}} nA7={{nA7}} nA8={{nA8}} nB1={{nB1}} nB2={{nB2}} nB3={{nB3}} nB4={{nB4}} nB5={{nB5}} nB6={{nB6}} nB7={{nB7}} nB8={{nB8}}

{% if fet_num == 7 %}
include "{{lstp_path}}/7nfet.pm"
include "{{lstp_path}}/7pfet.pm"
{% elif fet_num == 10 %}
include "{{lstp_path}}/10nfet.pm"
include "{{lstp_path}}/10pfet.pm"
{% elif fet_num == 14 %}
include "{{lstp_path}}/14nfet.pm"
include "{{lstp_path}}/14pfet.pm"
{% elif fet_num == 16 %}
include "{{lstp_path}}/16nfet.pm"
include "{{lstp_path}}/16pfet.pm"
{% elif fet_num == 20 %}
include "{{lstp_path}}/20nfet.pm"
include "{{lstp_path}}/20pfet.pm"
{% endif %}

*--- TOPOLOGY ---*
*--- differential_rail_to_rail_folded_cascode_ota_complementary Vbiasn0 Vbiasn1 Vbiasn2 Vbiasp0 Vbiasp1 Vbiasp2 Vinn Vinp Voutn Voutp ---*
*.PININFO Vbiasn0:I Vbiasn1:I Vbiasn2:I Vbiasp0:I Vbiasp1:I Vbiasp2:I Vinn:I Vinp:I Voutn:O Voutp:O
MM0 net10 Vbiasn0 gnd! gnd! nfet l=nA1 nfin=nB1
MM1 net11 Vinn net10 gnd! nfet l=nA2 nfin=nB2
MM2 net12 Vinp net10 gnd! nfet l=nA2 nfin=nB2
MM3 net13 Vbiasp1 vdd! vdd! pfet l=nA3 nfin=nB3
MM4 net14 Vinn net13 vdd! pfet l=nA4 nfin=nB4
MM5 net15 Vinp net13 vdd! pfet l=nA4 nfin=nB4
MM6 net11 Vbiasp0 vdd! vdd! pfet l=nA5 nfin=nB5
MM7 net12 Vbiasp0 vdd! vdd! pfet l=nA5 nfin=nB5
MM8 net14 Vbiasn1 gnd! gnd! nfet l=nA6 nfin=nB6
MM9 net15 Vbiasn1 gnd! gnd! nfet l=nA6 nfin=nB6
MM10 Voutn Vbiasp2 net12 vdd! pfet l=nA7 nfin=nB7
MM11 Voutn Vbiasn2 net15 gnd! nfet l=nA8 nfin=nB8
MM12 Voutp Vbiasp2 net11 vdd! pfet l=nA7 nfin=nB7
MM13 Voutp Vbiasn2 net14 gnd! nfet l=nA8 nfin=nB8

*--- BIAS VALUES ---*
VN0 (Vbiasn0 gnd!) vsource dc=vbiasn0 type=dc
VN2 (Vbiasn2 gnd!) vsource dc=vbiasn2 type=dc
VP0 (Vbiasp0 gnd!) vsource dc=vbiasp0 type=dc
VP1 (Vbiasp1 gnd!) vsource dc=vbiasp1 type=dc
VP2 (Vbiasp2 gnd!) vsource dc=vbiasp2 type=dc

VN1_nom (Vbiasn1_nom 0) vsource dc=vbiasn1 type=dc
E_bias_sum (Vbiasn1 Vbiasn1_nom Vcmfb_adj 0) vcvs gain=1

*--- TESTBENCH ---*
VS (gnd! 0) vsource dc=0 type=dc
V0 (vdd! gnd!) vsource dc=vdd ac=1 type=dc
V1 (cm gnd!) vsource dc=vcm type=dc

V_mode (mode_ctrl 0) vsource dc=0 type=dc

E_sense_p (Vcm_part1 0 Voutp 0) vcvs gain=0.5
E_sense_n (Vcm_out Vcm_part1 Voutn 0) vcvs gain=0.5
E_cmfb_amp (Vcmfb_pre 0 Vcm_out cm) vcvs gain=100

R_cmfb_pole (Vcmfb_pre Vcmfb_adj) resistor r=1M
C_cmfb_pole (Vcmfb_adj 0) capacitor c=1p

Vsig (sig_node 0) vsource type=sine dc=dc_offset mag=1 \
    ampl=0 freq=100M val0=0 delay=5n rise=50p fall=50p width=100n period=200n

E_pos (Vinp_pre cm sig_node 0) vcvs gain=0.5
E_neg (Vinn_pre cm sig_node 0) vcvs gain=-0.5

Rsrc_p (Vinp_pre Vinp_src) resistor r=rsrc_val
Rsrc_n (Vinn_pre Vinn_src) resistor r=rsrc_val

S_Rin_p (Vinp Vinp_src mode_ctrl 0) relay ropen=1T rclosed=1m vt1=0.1 vt2=0.9
S_Rin_n (Vinn Vinn_src mode_ctrl 0) relay ropen=1T rclosed=1m vt1=0.1 vt2=0.9

X_probe (Voutp Voutn Vfb_node_p Vfb_node_n) cmdmprobe

S_Rfb_p (Vfb_node_p Vinn mode_ctrl 0) relay ropen=rfeedback_val rclosed=1T vt1=0.1 vt2=0.9
S_Rfb_n (Vfb_node_n Vinp mode_ctrl 0) relay ropen=rfeedback_val rclosed=1T vt1=0.1 vt2=0.9

S_Runity_p (Vfb_node_p Voutp mode_ctrl 0) relay ropen=1T rclosed=1m vt1=0.1 vt2=0.9
S_Runity_n (Vfb_node_n Voutn mode_ctrl 0) relay ropen=1T rclosed=1m vt1=0.1 vt2=0.9

Cload_p (Voutp gnd!) capacitor c=cload_val
Cload_n (Voutn gnd!) capacitor c=cload_val

*--- SIMULATOR OPTIONS ---*
simulatorOptions options rawfmt=psfbin psfversion="1.4.0" reltol=1e-4 vabstol=1e-6 \
    iabstol=1e-12 temp=tempc tnom=27 scalem=1.0 scale=1.0 gmin=1e-12 rforce=1 \
    cmin=1f homotopy=all

*--- SIMULATION TIER 1 ---*
{% if run_gatekeeper %}
set_char_mode alter dev=V_mode param=dc value=0

dcOp_sim dc
stb_sim stb probe=X_probe start=1 stop=100G dec=10
xf_sim (Voutp Voutn) xf start=1 stop=100G dec=10
noise_sim (Voutp Voutn) noise start=1 stop=100G dec=10 iprobe=Vsig

set_cm_mode alter dev=E_neg param=gain value=0.499
xf_cm_sim (Voutp Voutn) xf start=1 stop=100G dec=10

set_diff_mode alter dev=E_neg param=gain value=-0.5
xf_psrr (Voutp Voutn) xf dev=V0 start=1 stop=100G dec=10
{% endif %}

*--- SIMULATION TIER 2 ---*
{% if run_full_char %}
set_unity_mode alter dev=V_mode param=dc value=1

swing_sweep dc param=dc_offset start=(-0.5*vdd) stop=(0.5*vdd) step=2m

set_src_sine alter dev=Vsig param=ampl value=(0.1 * vdd)
thd_pss pss fund=100M harms=10 tstab=200n errpreset=moderate

set_src_pulse alter dev=Vsig param=type value=pulse
set_src_val_small alter dev=Vsig param=val1 value=(0.05 * vdd)
settle_small_tran tran stop=50n step=5p errpreset=conservative

set_src_val_large alter dev=Vsig param=val1 value=(0.2 * vdd)
slew_large_tran tran stop=100n step=5p errpreset=conservative
{% endif %}

*--- DATA EXPORT ---*
dcOpInfo info what=oppoint where=rawfile
modelParameter info what=models where=rawfile
element info what=inst where=rawfile
outputParameter info what=output where=rawfile
designParamVals info what=parameters where=rawfile
primitives info what=primitives where=rawfile
subckts info what=subckts where=rawfile
save V0:p Voutp Voutn Vinp Vinn MM0:gm MM0:vgs MM0:vds MM0:ids MM0:region MM1:gm MM1:vgs MM1:vds MM1:ids MM1:region MM2:gm MM2:vgs MM2:vds MM2:ids MM2:region MM3:gm MM3:vgs MM3:vds MM3:ids MM3:region MM4:gm MM4:vgs MM4:vds MM4:ids MM4:region MM5:gm MM5:vgs MM5:vds MM5:ids MM5:region MM6:gm MM6:vgs MM6:vds MM6:ids MM6:region MM7:gm MM7:vgs MM7:vds MM7:ids MM7:region MM8:gm MM8:vgs MM8:vds MM8:ids MM8:region MM9:gm MM9:vgs MM9:vds MM9:ids MM9:region MM10:gm MM10:vgs MM10:vds MM10:ids MM10:region MM11:gm MM11:vgs MM11:vds MM11:ids MM11:region MM12:gm MM12:vgs MM12:vds MM12:ids MM12:region MM13:gm MM13:vgs MM13:vds MM13:ids MM13:region
saveOptions options save=allpub rawfmt=psfbin
